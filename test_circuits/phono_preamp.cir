* C:\Users\kevin\Documents\Uni\BA\Projekt\Testschaltkreise\phono_preamp.sch

* Schematics Version 8.0 - July 1997
* Thu Oct 29 09:43:52 2026

** Analysis setup **
.ac DEC 101 10 30k
.OP
.STMLIB "phono_preamp.stl"

* From [SCHEMATICS NETLIST] section of msim.ini:
.lib "D:\MSim_8\lib\OPAMP.LIB"
.lib "D:\MSim_8\lib\mos.lib"
.lib "D:\MSim_8\lib\EBIPOLAR.LIB"
.lib "D:\MSim_8\lib\User\RASH_PCE3_MODEL.LIB"
.lib "D:\MSim_8\lib\ts.lib"
.lib "D:\msim_8\lib\nom.lib"

.INC "phono_preamp.net"
.INC "phono_preamp.als"

.probe

.END
